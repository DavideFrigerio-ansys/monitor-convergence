# Ansys Electronics Desktop project, version 2023.2
project datasets:
  $Ceramic_material_39: (-273.15, 0.067032967) (-196.15, 0.067032967) (99.85, 1) (726.85, 1)
materials:
  Al-Extruded: thermal_conductivity=205 mass_density=2800 specific_heat=900 thermal_material_type=Solid
  air: permittivity=1.0006 permeability=1.0000004 thermal_conductivity=0.0261 mass_density=1.1614 specific_heat=1005 thermal_expansion_coefficient=0.00333 thermal_material_type=Fluid diffusivity=2.88e-05 molecular_mass=0.028966 viscosity=1.84e-05 material_refractive_index=1.000293
  PCB_Material: thermal_conductivity{anisotropic component1=20 component2=2 component3=20} mass_density=1 specific_heat=1 thermal_expansion_coefficient=1
  Ceramic_material: thermal_modifier{Property=specific_heat free_form_value=pwl($Ceramic_material_39,Temp)} thermal_conductivity=15 mass_density=3970 specific_heat=910 thermal_material_type=Solid
surface materials:
  Steel-oxidised-surface: surface_emissivity=0.8

design IcepakDesign1 (Icepak, SteadyState TemperatureAndFlow, model units mm)
options: Default_Fluid_Material=air Default_Solid_Material=Al-Extruded Default_Surface_Material=Steel-Oxidised-surface AmbientTemperature=20cel AmbientPressure=0n_per_meter_sq AmbientRadiationTemperature=20cel Gravity_Vector_CS_ID=Global Gravity_Vector_Axis=X Positive=true SherlockExportDirectory="C:/Program Files/AnsysEM/v232/Win64/Examples/Icepak/Graphics_Card.aedtexport/IcepakDesign1/" Altitude=0meter
geometry:
  Region [air] = region(percentage_offset=100 on all sides)
  SERIAL_PORT, MEMORY1, MEMORY1_1, CAPACITOR, CAPACITOR_1, KB [Ceramic_material, surface Steel-oxidised-surface] = imported_body(D:\AnsysEM\AnsysEM18.1\Win64\Examples\Icepak\Graphics Card\graphics_card_simple.stp)
  HEAT_SINK [Al-Extruded, surface Steel-oxidised-surface] = imported_body(D:\AnsysEM\AnsysEM18.1\Win64\Examples\Icepak\Graphics Card\graphics_card_simple.stp)
  CPU [Ceramic_material, surface Steel-oxidised-surface] = imported_body(D:\AnsysEM\AnsysEM18.1\Win64\Examples\Icepak\Graphics Card\graphics_card_simple.stp)
  ALPHA_MAIN_PCB [PCB_Material, surface Steel-oxidised-surface] = imported_body(D:\AnsysEM\AnsysEM18.1\Win64\Examples\Icepak\Graphics Card\graphics_card_simple.stp)
  point CPU_Monitor = (-37mm, 3.086mm, -43mm)
  point Memory_Monitor = (-35mm, 3.6mm, -86mm)
  point Point1 = (80mm, 14.243mm, -55mm)
  plane Plane1 = base (0mm, 1.6mm, -55mm) normal (0mm, 0mm, 5mm)
  Box1 [non-model] = box(corner=(-72mm, -5mm, -63mm), size=(67mm, 38mm, 52mm))
  group graphics_card_simple = SERIAL_PORT, MEMORY1, MEMORY1_1, CAPACITOR, CAPACITOR_1, KB, HEAT_SINK, CPU, ALPHA_MAIN_PCB
boundaries and excitations:
  CPU: Block Objects=CPU Block_Type=Solid Use_Total_Power Total_Power=25W
  Memory: Block Objects=[MEMORY1, MEMORY1_1] Block_Type=Solid Use_Total_Power Total_Power=5W
  Opening1: Opening Faces=Region.face(all 6) Temperature=AmbientTemp External_Rad._Temperature=AmbientRadTemp Inlet_Type=Pressure Total_Pressure=AmbientPressure
mesh:
  MeshRegions:  Global{MeshMethod=MesherHD ComputeGap MeshRegionResolution=3 MinGapX=1mm MinGapY=1mm MinGapZ=1mm Objects=Region FacetLevel=3 ProximitySizeFunction CurvatureSizeFunction OptimizePCBMesh}
  MeshOperations:
monitors:
  PointMonitor2: Quantities(19) Points=#483
setups:
  Setup1: IcepakSteadyState Flow_Regime=Turbulent Turbulent_Model_Eqn=ZeroEquation Include_Temperature=true Include_Flow=true Include_Gravity Solution_Initialization_-_Y_Velocity=0.000980665m_per_sec Convergence_Criteria_-_Flow=0.01 Convergence_Criteria_-_Energy=0.01 Convergence_Criteria_-_Turbulent_Kinetic_Energy=1e-07 Convergence_Criteria_-_Turbulent_Dissipation_Rate=1e-07 Convergence_Criteria_-_Specific_Dissipation_Rate=0.001 Radiation_Model=Off Under-relaxation_-_Pressure=0.7 Under-relaxation_-_Momentum=0.3 Under-relaxation_-_Temperature=1 Under-relaxation_-_Turbulent_Kinetic_Energy=0.8 Under-relaxation_-_Turbulent_Dissipation_Rate=0.8 Under-relaxation_-_Specific_Dissipation_Rate=0.8 Discretization_Scheme_-_Pressure=Standard Discretization_Scheme_-_Momentum=First Discretization_Scheme_-_Temperature=First Discretization_Scheme_-_Turbulent_Kinetic_Energy=First Discretization_Scheme_-_Turbulent_Dissipation_Rate=First Discretization_Scheme_-_Specific_Dissipation_Rate=First Convergence_Criteria_-_Max_Iterations=1000
field plots:
  Temperature1: Temperature over SERIAL_PORT, MEMORY1, MEMORY1_1, CAPACITOR, CAPACITOR_1, KB, HEAT_SINK, CPU, ALPHA_MAIN_PCB on Setup1 : SteadyState
